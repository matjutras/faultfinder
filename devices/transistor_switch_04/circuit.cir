* NPN Transistor Switch - FaultFinder device transistor_switch_04
V1 VCC 0 DC 9
R1 VCC BASE 10k
R2 BASE 0 10k
RC VCC COL 1k
Q1 COL BASE 0 QMOD
.model QMOD NPN
.end
